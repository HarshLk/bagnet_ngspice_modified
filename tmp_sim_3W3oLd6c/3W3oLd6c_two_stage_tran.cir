two_stage_amp transient test

* Two stage OPAMP
.include "/home/harsh/Desktop/Projects & Competitions/Silicon Talks/bagnet_ngspice/bb_envs/src/ngspice/models/45nm_bulk.txt"
.param wp1=0.5u lp1=90n mp1=15
.param wn1=0.5u ln1=90n mn1=72
.param wn3=0.5u ln3=90n mn3=12
.param wp3=0.5u lp3=90n mp3=68
.param wn4=0.5u ln4=90n mn4=8
.param wn5=0.5u ln5=90n mn5=27
.param cc=4.9000000000000005e-12
.param ibias=30u
.param cload=10p
.param vcm=0.6

mp1 net4 net4 VDD VDD pmos w=wp1 l=lp1 m=mp1
mp2 net5 net4 VDD VDD pmos w=wp1 l=lp1 m=mp1
mn1 net4 net2 net3 net3 nmos w=wn1 l=ln1 m=mn1
mn2 net5 net1 net3 net3 nmos w=wn1 l=ln1 m=mn1
mn3 net3 net7 VSS VSS nmos w=wn3 l=ln3 m=mn3
mn4 net7 net7 VSS VSS nmos w=wn4 l=ln4 m=mn4
mp3 net6 net5 VDD VDD pmos w=wp3 l=lp3 m=mp3
mn5 net6 net7 VSS VSS nmos w=wn5 l=ln5 m=mn5
cc net5 net6 cc
ibias VDD net7 ibias

vin net1 cm PULSE(0 20m 0 10p 10p 0.5)
vcm cm 0 dc=vcm
vnn net6 net2 dc=0

vdd VDD 0 dc=1.2
vss 0 VSS dc=0
CL net6 0 cload

.tran 100p 1u

.control
run
set units=degrees
set wr_vecnames
option numdgt=7
wrdata designs_two_stage_tran/two_stage_tran_3W3oLd6c/tran.csv v(net6) v(net1) i(vdd)
.endc

.end
